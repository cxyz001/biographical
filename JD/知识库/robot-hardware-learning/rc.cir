RC learning circuit, ideal low-voltage model
V1 in 0 PULSE(0 3.3 1m 1u 1u 10m 20m)
R1 in out 10k
C1 out 0 100n
.tran 10u 40m
.control
run
print v(out)
.endc
.end
